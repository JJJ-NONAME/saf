# Ansys Electronics Desktop project, version 2023.1
materials:
  vacuum: permittivity=1
  Copper (Annealed)_65C: permeability=1 conductivity=49288049
  Arnold_Magnetics_N30UH_80C_new: permeability{HUnit=A_per_meter BUnit=tesla curve (-1406000, -1.8289) (-1402000, -1.2532) (-1394000, -0.9938) (-1373000, -0.84) (-1357000, -0.7872) (-1340000, -0.7492) (-1323000, -0.7175) (-1307000, -0.6891) (-1290000, -0.6626) (-1274000, -0.6373) (-1257000, -0.6129) (-1241000, -0.589) (-1224000, -0.5655) (-1208000, -0.5424) (-1191000, -0.5195) (-1175000, -0.4968) (-1158000, -0.4742) (-1142000, -0.4518) (-1125000, -0.4295) (-1108000, -0.4073) (-1092000, -0.3851) (-1075000, -0.363) (-1059000, -0.341) (-1042000, -0.319) (-1026000, -0.297) (-1009000, -0.2751) (-993000, -0.2532) (-976000, -0.2314) (-960000, -0.2096) (-943000, -0.1877) (-926000, -0.166) (-910000, -0.1442) (-893000, -0.1224) (-877000, -0.1007) (-860000, -0.079) (-844000, -0.0573) (-827000, -0.0356) (-811000, -0.0139) (-794000, 0.0078) (-778000, 0.0295) (-761000, 0.0512) (-744000, 0.0728) (-728000, 0.0945) (-711000, 0.1161) (-695000, 0.1377) (-678000, 0.1594) (-662000, 0.181) (-645000, 0.2026) (-629000, 0.2243) (-612000, 0.2459) (-596000, 0.2675) (-579000, 0.2891) (-562000, 0.3107) (-546000, 0.3323) (-529000, 0.3539) (-513000, 0.3755) (-496000, 0.3971) (-480000, 0.4187) (-463000, 0.4402) (-447000, 0.4618) (-430000, 0.4834) (-414000, 0.505) (-397000, 0.5266) (-381000, 0.5481) (-364000, 0.5697) (-347000, 0.5913) (-331000, 0.6129) (-314000, 0.6344) (-298000, 0.656) (-281000, 0.6776) (-265000, 0.6991) (-248000, 0.7207) (-232000, 0.7422) (-215000, 0.7638) (-199000, 0.7854) (-182000, 0.8069) (-165000, 0.8285) (-149000, 0.85) (-132000, 0.8716) (-116000, 0.8931) (-99000, 0.9147) (-83000, 0.9363) (-66000, 0.9578) (-50000, 0.9794) (-33000, 1.0009) (-17000, 1.0225) (0, 1.044)} conductivity=555555.5556 magnetic_coercivity{Magnitude=7500A_per_meter DirComp1=1 DirComp2=0 DirComp3=0}
  30DH_20C_smooth: permeability{HUnit=A_per_meter BUnit=tesla curve (0, 0) (10.005, 0.034) (15.007, 0.057) (20.01, 0.09) (30.015, 0.198) (40.034, 0.37) (50.048, 0.562) (60.061, 0.748) (67.279491, 0.86001904) (76.339295, 0.95826253) (87.601403, 1.0436786) (101.4268, 1.1172155) (118.17649, 1.1798212) (138.21145, 1.2324441) (161.89267, 1.2760321) (189.58114, 1.3115336) (221.63786, 1.3398966) (258.42382, 1.3620694) (300.3, 1.379) (400.8, 1.412) (500.8, 1.434) (600.8, 1.452) (800.9, 1.478) (1001, 1.498) (2005.5, 1.567) (2506, 1.593) (5013, 1.688) (8016, 1.769) (10017, 1.811) (14979.352, 1.871871516) (30018.718, 1.923961998) (55616.408, 1.963927948) (92665.593, 2.012536477) (142649.57, 2.076015733) (208013.6, 2.158412749) (293010.73, 2.265336973) (406010.2, 2.407391643) (568476.41, 2.611582176) (1000000, 3.153871481)} conductivity=1694915.3 core_loss_type="Electrical Steel" core_loss_kh=71.718099 core_loss_kc=0.25092215 core_loss_ke=12.162577 core_loss_kdc=0.001 mass_density=7650 core_loss_equiv_cut_depth=0.001meter
surface materials:
  Steel-oxidised-surface

design Sinusoidal (Maxwell 2D, Transient, XY geometry, model units mm)
options: ComputeTransientInductance ModelDepth=Magnetic_Axial_Length
variables:
  DiaGap = 132mm
  DiaStatorYoke = 198mm
  DiaStatorInner = 132mm
  DiaRotorLam = 130mm
  DiaShaft = 44.45mm
  DiaOuter = 198mm
  Airgap = 1mm
  SlotNumber = 48
  SlotType = 3
  DiaSmallHoles = 5.1mm
  DiaBigHole = 9.88mm
  L_Drl_PM_O = 2.28mm
  Layers = 1
  ParallelPaths = 2
  R_Phase = 7.5mOhm
  WdgExt_F = 5mm
  SpanExt = 30mm
  SegAngle = 0.25
  CoilPitch = 5
  Coil_SetBack = 3.605732823mm
  SlotWidth = 2.814mm
  Coil_Edge_Short = 3.769235435mm
  Coil_Edge_Long = 15.37828521mm
  NumPoles = 8
  Model_Length = 80mm
  SymmetryFactor = 8
  Magnetic_Axial_Length = 150mm
  Stator_Lam_Length = 0mm
  StatorSkewAngle = 0deg
  NumTorquePointsPerCycle = 30
  mapping_angle = 0.125*4deg
  num_m = 16
  Section_Angle = 360deg/SymmetryFactor
  InitialPositionMD = 180deg/4
  IPeak = 480A
  MachineRPM = 3000rpm
  ElectricFrequency = MachineRPM/60rpm*NumPoles/2*1Hz
  ElectricPeriod = 1Hz/ElectricFrequency
  BandTicksinModel = 360deg/NumPoles/mapping_angle
  TimeStep = ElectricPeriod/(2*BandTicksinModel)
  StopTime = 2*ElectricPeriod
  Theta_i = 135deg
  P_at_1000 = 15
  d_move_PM_O = -0.000129529mm
geometry:
  Stator [30DH_20C_smooth] = user_primitive(RMxprt/VentSlotCore.dll, DiaGap=DiaGap, DiaYoke=DiaStatorYoke, Length=Stator_Lam_Length, Skew=StatorSkewAngle, Slots=SlotNumber, SlotType=SlotType, Hs0=1.2mm, Hs01=0mm, Hs1=0.48342274mm, Hs2=17.28767mm, Bs0=2.814mm, Bs1=4.7115411mm, Bs2=6.9777286mm, Rs=2mm, FilletType=1, HalfSlot=0, VentHoles=0, HoleDiaIn=0mm, HoleDiaOut=0mm, HoleLocIn=0mm, HoleLocOut=0mm, VentDucts=0, DuctWidth=0mm, DuctPitch=0mm, SegAngle=0deg, LenRegion=Model_Length, InfoCore=0)
  PM_I1 [Arnold_Magnetics_N30UH_80C_new, oriented by CS_PM_I1] = polyline(z=0mm, xy in mm: (56.70957112, 3.104886585) (40.25081875, 16.67243502) (38.59701538, 14.66621111) (55.05576774, 1.098662669) (56.70957112, 3.104886585), closed, covered)
  PM_O1 [Arnold_Magnetics_N30UH_80C_new, oriented by CS_PM_O1] = polyline(z=0mm, xy in mm: (54.37758185, 22.52393189) (59.69688156, 9.68200639) (63.26490432, 11.15992981) (57.94560461, 24.00185531) (54.37758185, 22.52393189), closed, covered)
  coordinate_system CS_PM_I1 = face of PM_I1: Origin=(47.653293, 8.8855488, 0) MoveToEnd FaceID=PM_I1.face(at (47.6533, 8.88555, 0)) AxisPosn=(48.480195, 9.8886608, 0) WhichAxis=X ZRotationAngle=0deg XOffset=0mm YOffset=0mm FaceNormal(0, 0, 1)
  PM_O1.move(-d_move_PM_O*cos((360deg/SymmetryFactor/2)), -d_move_PM_O*sin((360deg/SymmetryFactor/2)), 0mm)
  coordinate_system CS_PM_O1 = face of PM_O1: Origin=(58.821363, 16.84198, 0) MoveToEnd FaceID=PM_O1.face(#992) AxisPosn=(60.605374, 17.580942, 0) WhichAxis=X ZRotationAngle=0deg XOffset=0mm YOffset=0mm FaceNormal(0, 0, 1)
  PM_I1_1 [Arnold_Magnetics_N30UH_80C_new, oriented by FaceCS1] = PM_I1.duplicate_mirror(point=(0mm, 0mm, 0mm), normal=(cos((360deg/SymmetryFactor/2)+90deg), sin((360deg/SymmetryFactor/2)+90deg), 0mm))
  coordinate_system FaceCS1 = face of PM_I1_1: Origin=(39.978999, 27.412935, 0) MoveToEnd FaceID=PM_I1_1.face AxisPosn=(41.273014, 27.288335, 0) WhichAxis=X ZRotationAngle=0deg XOffset=0mm YOffset=0mm FaceNormal(0, 0, 1)
  PM_O1_1 [Arnold_Magnetics_N30UH_80C_new, oriented by FaceCS2] = PM_O1.duplicate_mirror(point=(0mm, 0mm, 0mm), normal=(cos((360deg/SymmetryFactor/2)+90deg), sin((360deg/SymmetryFactor/2)+90deg), 0mm))
  coordinate_system FaceCS2 = face of PM_O1_1: Origin=(53.502063, 29.683906, 0) MoveToEnd FaceID=PM_O1_1.face AxisPosn=(55.286074, 30.422868, 0) WhichAxis=X ZRotationAngle=0deg XOffset=0mm YOffset=0mm FaceNormal(0, 0, 1)
  Coil [Copper (Annealed)_65C] = rectangle(corner=(DiaRotorLam/2+Airgap+Coil_SetBack, -Coil_Edge_Short/2, 0mm), x_size=Coil_Edge_Long, y_size=Coil_Edge_Short)
  Coil.rotate(axis=Z, angle=360deg/SlotNumber/2)
  Coil_1..Coil_5 [Copper (Annealed)_65C] = Coil.duplicate_around_axis(axis=Z, angle=360deg/SlotNumber, total=CoilPitch+1)
  Region [vacuum] = circle(normal=Z, centre=(0mm, 0mm, 0mm), radius=DiaOuter/2, segments=SegAngle)
  Shaft [vacuum] = circle(normal=Z, centre=(0mm, 0mm, 0mm), radius=DiaShaft/2, segments=SegAngle)
  RotatingBand_in [vacuum] = circle(normal=Z, centre=(0mm, 0mm, 0mm), radius=(DiaGap - (1.5 * Airgap))/2, segments=mapping_angle)
  RotatingBand_mid [vacuum] = circle(normal=Z, centre=(0mm, 0mm, 0mm), radius=(DiaGap - (1.0 * Airgap))/2, segments=mapping_angle)
  RotatingBand_out [vacuum] = circle(normal=Z, centre=(0mm, 0mm, 0mm), radius=(DiaGap - (0.5 * Airgap))/2, segments=mapping_angle)
  Rotor [30DH_20C_smooth] = circle(normal=Z, centre=(0mm, 0mm, 0mm), radius=DiaRotorLam/2)
  Shaft_1 = Shaft.copy()
  Rotor.subtract(Shaft_1)
  void1 = circle(normal=Z, centre=(62mm, 0mm, 0mm), radius=DiaSmallHoles/2)
  void1.duplicate_around_axis(axis=Z, angle=360deg/SymmetryFactor, total=2, attached)
  void_big = circle(normal=Z, centre=(29.5643mm, 12.234389mm, 0mm), radius=DiaBigHole/2)
  Rotor.subtract(void1, void_big)
  slot_IM1 [vacuum] = polyline(z=0mm, xy in mm: (37.5302872, 15.54555396) (55.05576774, 1.098662669) (57.33637589, 1.25) (57.28982158, 2.626565019) (40.25081875, 16.67243502) (37.5302872, 15.54555396), closed, covered)
  slot_OM1 [vacuum] = polyline(z=0mm, xy in mm: (54.37758185, 22.52393189) (59.69688156, 9.68200639) (63.53825619, 10.5) (57.94560461, 24.00185531) (54.37758185, 22.52393189), closed, covered)
  slot_OM1.move(-d_move_PM_O*cos((360deg/SymmetryFactor/2)), -d_move_PM_O*sin((360deg/SymmetryFactor/2)), 0mm)
  slot_IM1_1 [vacuum] = slot_IM1.duplicate_mirror(point=(0mm, 0mm, 0mm), normal=(cos((360deg/SymmetryFactor/2)+90deg), sin((360deg/SymmetryFactor/2)+90deg), 0mm))
  slot_OM1_1 [vacuum] = slot_OM1.duplicate_mirror(point=(0mm, 0mm, 0mm), normal=(cos((360deg/SymmetryFactor/2)+90deg), sin((360deg/SymmetryFactor/2)+90deg), 0mm))
  slot_IM1_2 = slot_IM1.copy()
  slot_OM1_2 = slot_OM1.copy()
  slot_IM1_1_1 = slot_IM1_1.copy()
  slot_OM1_1_1 = slot_OM1_1.copy()
  Rotor.subtract(slot_IM1_2, slot_OM1_2, slot_IM1_1_1, slot_OM1_1_1)
  coordinate_system Section = origin=(0mm, 0mm, 0mm) x=(cos(360deg/SymmetryFactor), sin(360deg/SymmetryFactor), 0mm) y=(-sin(360deg/SymmetryFactor), cos(360deg/SymmetryFactor), 0mm)
  [Stator, Rotor, Shaft, Region, RotatingBand_in, RotatingBand_mid, RotatingBand_out].split(plane=ZX, keep=NegativeOnly) in Section
  [Stator, Rotor, Shaft, Region, RotatingBand_in, RotatingBand_mid, RotatingBand_out].split(plane=ZX, keep=PositiveOnly)
motion:
  MotionSetup1: Band Move_Type=Rotate Coordinate_System=Global Axis=Z Is_Positive=true InitPos=InitialPositionMD NegativePos=0deg PositivePos=360deg Angular_Velocity=MachineRPM Objects=RotatingBand_mid
  Moving1: Moving Objects=[PM_I1, PM_O1, PM_I1_1, PM_O1_1, Shaft, RotatingBand_in, Rotor, slot_IM1, slot_OM1, slot_IM1_1, slot_OM1_1]
boundaries and excitations:
  Matching: Independent Edges=Region.edge(at (49.5, 0, 0))
  Matching_dep: Dependent Edges=Region.edge(at (35.0018, 35.0018, 0)) ReverseU Independent=Matching SameAsMaster=false
  VectorPotentialZero: Vector Potential Edges=Region.edge(at (91.4641, 37.8857, 0)) Value=0
  CT_Ph1_P2_C1_Go: Coil Objects=Coil Conductor_number=6 Winding=Phase_A PolarityType=Positive
  CT_Ph1_P2_C1_Ret: Coil Objects=Coil_5 Conductor_number=6 Winding=Phase_A PolarityType=Negative
  CT_Ph3_P1_C2_Go: Coil Objects=Coil_3 Conductor_number=6 Winding=Phase_B PolarityType=Positive
  CT_Ph3_P1_C1_Go: Coil Objects=Coil_4 Conductor_number=6 Winding=Phase_B PolarityType=Positive
  CT_Ph2_P2_C2_Ret: Coil Objects=Coil_1 Conductor_number=6 Winding=Phase_C PolarityType=Negative
  CT_Ph2_P2_C1_Ret: Coil Objects=Coil_2 Conductor_number=6 Winding=Phase_C PolarityType=Negative
  PM_I1_I0: Current Objects=PM_I1 Current=0A IsSolid=true IsPositive=false
  PM_O1_I0: Current Objects=PM_O1 Current=0A IsSolid=true IsPositive=false
  PM_I1_1_I0: Current Objects=PM_I1_1 Current=0A IsSolid=true IsPositive=false
  PM_O1_1_I0: Current Objects=PM_O1_1 Current=0A IsSolid=true IsPositive=false
  Phase_A: Winding Group Type=Current IsSolid=false Current="IPeak * cos(2*pi*ElectricFrequency*time+Theta_i)" ParallelBranchesNum=1
  Phase_B: Winding Group Type=Current IsSolid=false Current="IPeak * cos(2*pi * ElectricFrequency*time - 120deg+Theta_i)" ParallelBranchesNum=1
  Phase_C: Winding Group Type=Current IsSolid=false Current="IPeak * cos(2*pi * ElectricFrequency*time - 240deg+Theta_i)" ParallelBranchesNum=1
  eddy effects on: PM_I1, PM_O1, PM_I1_1, PM_O1_1
  core loss on: Stator, Rotor
mesh:
  CylindricalGap1: CylindricalGap Objects=RotatingBand_mid BandMappingAngle=3deg Objects=RotatingBand_mid
  coils: LengthBased RefineInside Objects=[Coil, Coil_1..Coil_5] MaxLength=3mm
  stator: LengthBased RefineInside Objects=Stator MaxLength=3mm
  rotor: LengthBased RefineInside Objects=Rotor MaxLength=3mm
setups:
  MySetupAuto: Transient NonlinearSolverResidual=0.005 StopTime=StopTime TimeStep=TimeStep OutputError OutputPerObjectCoreLoss OutputPerObjectSolidLoss InitialTimeStep=0.002s MinTimeStep=0.001s MaxTimeStep=0.003s TimeStepErrTolerance=0.0001
